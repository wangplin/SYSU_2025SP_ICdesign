.OPTIONS POST BRIEF

.OP
.LIB "/home/htj/smic40_oa/smic40ll_1125_1tm_oa_cds_1P9M_2012_10_11_v1.4/models/hspice/l0040ll_v1p4_1r.lib" tt
.TEMP 25

VDD vdd 0 DC 1.1

VIN lin 0 PULSE(0 1.1 0 10p 10p 5n 10n)

.TRAN 0.01n 50n UIC

.OPTIONS POST
.PRINT TRAN V(lin) V(lout)

.PARAM mos_w=330n
.PARAM mos_l=40n
.PARAM nmos_w=1200n
.PARAM nmos_l=120n
.PARAM pmos_w=1400n
.PARAM pmos_l=120n

.subckt NAND2 A B net_nand VDD GND
XP1 net_nand A VDD VDD p11ll_ckt W=mos_w L=mos_l
XP2 net_nand B VDD VDD p11ll_ckt W=mos_w L=mos_l
XN1 net_nand A net1 GND n11ll_ckt W=nmos_w L=nmos_l
XN2 net1 B GND GND n11ll_ckt W=nmos_w L=nmos_l
.ends

.subckt MUX select A B out VDD GND
XINV   select sel_n   VDD GND INV
XAND1  A select T VDD GND NAND2
XAND2  B sel_n  T VDD GND NAND2
XINV1   T OUT   VDD GND INV
.ends

.subckt INV A Y VDD GND
XP1 Y A VDD VDD p11ll_ckt W=mos_w*2 L=mos_l*2
XN1 Y A GND GND n11ll_ckt W=nmos_w*2 L=nmos_l*2
.ends

.subckt MUX4 select1 select2 A B C  D OUT VDD GND
XMUXAB0 select1 A B ABT VDD GND MUX
XMUXCD0 select1 C D CDT VDD GND MUX
XMUXABCD0 select2 ABT CDT OUT VDD GND MUX
.ends

.subckt FOURMUX select1 select2 A0 B0 C0 D0 A1 B1 C1 A2 B2 C2 D2 A3 B3 C3 D3 A4 B4 C4 D4 OUT4 A5 B5 C5 D5 OUT5 A6 B6 C6 D6 OUT6 A7 B7 C7 D7 OUT7 VDD GND
XMUX0 select1 select2 A0 B0 C0 D0 OUT0 VDD GND MUX4
XMUX1 select1 select2 A1 B1 C1 D1 OUT1 VDD GND MUX4
XMUX2 select1 select2 A2 B2 C2 D2 OUT2 VDD GND MUX4
XMUX3 select1 select2 A3 B3 C3 D3 OUT3 VDD GND MUX4
XMUX4 select1 select2 A4 B4 C4 D4 OUT4 VDD GND MUX4
XMUX5 select1 select2 A5 B5 C5 D5 OUT5 VDD GND MUX4
XMUX6 select1 select2 A6 B6 C6 D6 OUT6 VDD GND MUX4
XMUX7 select1 select2 A7 B7 C7 D7 OUT7 VDD GND MUX4
.ends

*00 01 10 11 1N
VSE1 select1 0 PULSE(0 1.1 0 10p 10p 1n 2.5n)
VSE2 select2 0 PULSE(0 1.1 0 10p 10p 2.5n 5n)
VINA0 A0 0 PULSE(0 1.1 0 10p 10p 5n 40n)
VINB0 B0 0 PULSE(0 1.1 10n 10p 10p 5n 40n)
VINC0 C0 0 PULSE(0 1.1 20n 10p 10p 5n 40n)
VIND0 D0 0 PULSE(0 1.1 30n 10p 10p 5n 40n)
VIN3 A1 0 PULSE(0 1.1 0 10p 10p 5n 10n)
VIN4 B1 0 PULSE(0 1.1 0 10p 10p 10n 20n)
VIN5 A2 0 PULSE(0 1.1 0 10p 10p 5n 10n)
VIN6 B2 0 PULSE(0 1.1 0 10p 10p 5n 10n)
VIN7 A3 0 PULSE(0 1.1 0 10p 10p 5n 10n)
VIN8 B3 0 PULSE(0 1.1 0 10p 10p 5n 10n)
VIN9 A4 0 PULSE(0 1.1 0 10p 10p 5n 10n)
VIN11 B4 0 PULSE(0 1.1 0 10p 10p 5n 10n)
VIN22 A5 0 PULSE(0 1.1 0 10p 10p 5n 10n)
VIN33 B5 0 PULSE(0 1.1 0 10p 10p 5n 10n)
VIN44 A6 0 PULSE(0 1.1 0 10p 10p 5n 10n)
VIN55 B6 0 PULSE(0 1.1 0 10p 10p 5n 10n)
VIN66 A7 0 PULSE(0 1.1 0 10p 10p 5n 10n)
VIN77 B7 0 PULSE(0 1.1 0 10p 10p 5n 10n)

X4MUX1 select1 select2 A0 B0 C0 D0 A1 B1 C1 A2 B2 C2 D2 A3 B3 C3 D3 A4 B4 C4 D4 OUT4 A5 B5 C5 D5 OUT5 A6 B6 C6 D6 OUT6 A7 B7 C7 D7 OUT7 VDD GND FOURMUX

.PRINT TRAN V(A0) V(B0) V(OUT0)

*C0 lout 0 1

.end
